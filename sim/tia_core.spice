* ============================================================
* RGC-CD TIA core subcircuit  (sky130A, LVT nfets)
*
* Nets:
*   V_S1 = V_G2   (M1 source = M2 gate = input node)
*   V_G1 = V_D2   (M1 gate  = M2 drain)   -> aux feedback
*   V_D1 = V_G3   (M1 drain = M3 gate)    -> RGC output
*   V_out = V_D3  (M3 drain = TIA output)
*
* Ideal passives. Real sky130 R/C
* devices are swapped in for Phase 3 layout/PEX.
*
* Sizing params (overridable by the testbench):
*   W1 /L12/NF12  -> M1        (known-good bias width)
*   W2 /L12/NF12  -> M2        (known-good bias width)
*   W3 /L3 /NF3   -> M3
*   CDEG          -> degeneration cap C1 (global, retunable)
* ============================================================
* Global degeneration cap.
*   450f  = prev. design value (sky130B) -> +16 dB over-peak on sky130A
*   13.5f = sky130A re-tune (20 fF load): CD zero at ~2 GHz RGC pole.
*   178f  = max-BW / min-current tune for a 1 pF ADC load (single-sided input):
*           f_z = f_out = 1/(2pi*R3*C_L) cancels the output pole. Large R5
*           (22.5k) + low I3 gives big gm3*R5 -> f_p ~ 631 MHz at 0.33 mW.
*           Starved front-end (R4=9k, R2=6k) keeps V_D1 high so M3 stays
*           well-biased.  R5*C1 = R3*C_L = 4 ns.  See sizing_worksheet.py.
* See sim/tb_ac_tune.spice for the sweep, sim/sizing_worksheet.py for the plan.
.param CDEG=178f
.subckt tia_core vin vout vdd vss
+ W1=7.3  W2=7.9  L12=0.15 NF12=1
+ W3=19.1 L3=0.15  NF3=1
+ R1=6.5k R2=6k R3=4k R4=9k R5=22.5k
+ AGATE=0

* --- RGC input stage ---------------------------------------
* M1: main cascode. d=D1(=G3), g=G1(=g1), s=S1(=vin), b=vss
XM1  d1  g1  vin vss sky130_fd_pr__nfet_01v8_lvt L={L12} W={W1} nf={NF12}
* RGC-loop break point: 0 V DC short (bias preserved) that also injects an AC
* test signal when AGATE=1 -> lets tb_stb.spice measure loop gain / phase margin.
Vinj d2  g1  dc 0 ac {AGATE}
* M2: auxiliary common-source amp. d=D2, g=G2(=vin), s=gnd
XM2  d2  vin vss vss sky130_fd_pr__nfet_01v8_lvt L={L12} W={W2} nf={NF12}
RR1  vdd d1  {R1}
RR2  vdd d2  {R2}
RR4  vin vss {R4}

* --- Capacitive-degeneration stage -------------------------
* M3: d=Vout, g=D1, s=S3, degenerated by R5||C1
XM3  vout d1  s3  vss sky130_fd_pr__nfet_01v8_lvt L={L3} W={W3} nf={NF3}
RR3  vdd  vout {R3}
RR5  s3   vss  {R5}
C1   s3   vss  {CDEG}
.ends tia_core
