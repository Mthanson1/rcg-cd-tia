* ============================================================
* RGC-CD TIA core -- REAL sky130 device passives (drop-in for tia_core.spice)
*
* Same subckt name / ports / AGATE loop-break as sim/tia_core.spice, but the
* ideal RR1..RR5 lumped resistors and the ideal C1 are replaced by the actual
* sky130 devices at the AS-DRAWN layout dimensions (see verify/tia_lay.spice /
* ip/tia.sch), and M1/M2/M3 use the layout finger counts (nf = 4 / 4 / 8):
*
*   R1  d1  <-> vdd   res_high_po_0p35   l=5.36   (ideal target 6.5k)
*   R2  d2  <-> vdd   res_high_po_0p35   l=4.91   (ideal target 6.0k)
*   R3  vout<-> vdd   res_high_po_0p35   l=3.10   (ideal target 4.0k)
*   R4  vin <-> vss   res_high_po_0p35   l=7.62   (ideal target 9.0k)
*   R5  s3  <-> vss   res_xhigh_po_0p69  l=7.87   (ideal target 22.5k)
*   C1  s3  <-> vss   cap_mim_m3_1  w=17 l=5      (ideal target 178 fF)
*
* Purpose: check whether the real device R/C values + their parasitics (and the
* real multi-finger FETs) move the bias / gain / bandwidth / phase margin vs the
* ideal-passive tia_core.spice.  W is TOTAL in the sky130 FET model, so nf does
* not change the total width (LVS-confirmed) -- bias should track, HF may shift.
* ============================================================
.subckt tia_core vin vout vdd vss
+ W1=7.3  W2=7.9  L12=0.15 NF12=4
+ W3=19.1 L3=0.15  NF3=8
+ AGATE=0

* --- RGC input stage ---------------------------------------
* M1: main cascode. d=D1(=G3), g=G1, s=vin, b=vss
XM1  d1  g1  vin vss sky130_fd_pr__nfet_01v8_lvt L={L12} W={W1} nf={NF12}
* RGC-loop break: 0 V DC short (bias preserved) injecting AC when AGATE=1
Vinj d2  g1  dc 0 ac {AGATE}
* M2: auxiliary common-source amp. d=D2, g=vin, s=vss
XM2  d2  vin vss vss sky130_fd_pr__nfet_01v8_lvt L={L12} W={W2} nf={NF12}
XR1  d1  vdd vss sky130_fd_pr__res_high_po_0p35 l=5.36 mult=1
XR2  d2  vdd vss sky130_fd_pr__res_high_po_0p35 l=4.91 mult=1
XR4  vin vss vss sky130_fd_pr__res_high_po_0p35 l=7.62 mult=1

* --- Capacitive-degeneration stage -------------------------
* M3: d=vout, g=d1, s=s3, degenerated by R5 || C1
XM3  vout d1  s3  vss sky130_fd_pr__nfet_01v8_lvt L={L3} W={W3} nf={NF3}
XR3  vout vdd vss sky130_fd_pr__res_high_po_0p35 l=3.1  mult=1
XR5  s3   vss vss sky130_fd_pr__res_xhigh_po_0p69 l=7.87 mult=1
XC1  s3   vss sky130_fd_pr__cap_mim_m3_1 w=17 l=5 mf=1
.ends tia_core
